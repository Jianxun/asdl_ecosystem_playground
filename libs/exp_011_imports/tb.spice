* Netlist generated by ASDL for backend `sim.xyce`

Xdut inp inn out vbn vdd vss ota_5t_op
V_vsrc_vdd vdd vss DC VDD
V_vsrc_vss vss 0 DC 0
V_vsrc_inp inp vss DC VCM
V_vsrc_inn inn vss DC VCM
I_isrc_bias vdd vbn DC 100e-6
R_rload out vss 10k
* GF180MCU Model Card:
.include /Users/jianxunzhu/Documents/GitHub/asdl_ecosystem/playground/pdks/gf180mcu/xyce/design.xyce
.lib /Users/jianxunzhu/Documents/GitHub/asdl_ecosystem/playground/pdks/gf180mcu/xyce/sm141064.xyce typical
.DC V_vsrc_inp VCM VCM 0.1

.PRINT DC FORMAT=raw V(*)

.PRINT DC FORMAT=raw I(*)

* ===============================================
* ota_5t_op
* /Users/jianxunzhu/Documents/GitHub/asdl_ecosystem/playground/libs/exp_011_imports/ota_5t_op.asdl
* ===============================================
.subckt ota_5t_op inp inn out vbn vdd vss
Xcore inp inn out vbn vdd vss ota_nmos
.ends ota_5t_op

* ===============================================
* ota_nmos
* /Users/jianxunzhu/Documents/GitHub/asdl_ecosystem/playground/libs/tb/tb_ota_5t/ota_nmos.asdl
* ===============================================
.subckt ota_nmos inp inn out vbn vdd vss
Xmp_ref d d vdd vdd pfet_03v3 L=0.5u W=6*5u nf=6 ad='int((nf+1)/2) * W/nf * 0.18u' as='int((nf+2)/2) * W/nf * 0.18u' pd='2*int((nf+1)/2) * (W/nf + 0.18u)'
+ ps='2*int((nf+2)/2) * (W/nf + 0.18u)' nrd='0.18u / W' nrs='0.18u / W' sa=0 sb=0 sd=0 m=3
Xmp_cs out d vdd vdd pfet_03v3 L=0.5u W=6*5u nf=6 ad='int((nf+1)/2) * W/nf * 0.18u' as='int((nf+2)/2) * W/nf * 0.18u' pd='2*int((nf+1)/2) * (W/nf + 0.18u)'
+ ps='2*int((nf+2)/2) * (W/nf + 0.18u)' nrd='0.18u / W' nrs='0.18u / W' sa=0 sb=0 sd=0 m=3
Xmn_in_p d inp tail vss nfet_03v3 L=0.5u W=6*5u nf=6 ad='int((nf+1)/2) * W/nf * 0.18u' as='int((nf+2)/2) * W/nf * 0.18u' pd='2*int((nf+1)/2) * (W/nf + 0.18u)'
+ ps='2*int((nf+2)/2) * (W/nf + 0.18u)' nrd='0.18u / W' nrs='0.18u / W' sa=0 sb=0 sd=0 m=1
Xmn_in_n out inn tail vss nfet_03v3 L=0.5u W=6*5u nf=6 ad='int((nf+1)/2) * W/nf * 0.18u' as='int((nf+2)/2) * W/nf * 0.18u' pd='2*int((nf+1)/2) * (W/nf + 0.18u)'
+ ps='2*int((nf+2)/2) * (W/nf + 0.18u)' nrd='0.18u / W' nrs='0.18u / W' sa=0 sb=0 sd=0 m=1
Xmn_tail tail vbn vss vss nfet_03v3 L=0.5u W=6*5u nf=6 ad='int((nf+1)/2) * W/nf * 0.18u' as='int((nf+2)/2) * W/nf * 0.18u' pd='2*int((nf+1)/2) * (W/nf + 0.18u)'
+ ps='2*int((nf+2)/2) * (W/nf + 0.18u)' nrd='0.18u / W' nrs='0.18u / W' sa=0 sb=0 sd=0 m=2
Xmn_diode vbn vbn vss vss nfet_03v3 L=0.5u W=6*5u nf=6 ad='int((nf+1)/2) * W/nf * 0.18u' as='int((nf+2)/2) * W/nf * 0.18u' pd='2*int((nf+1)/2) * (W/nf + 0.18u)'
+ ps='2*int((nf+2)/2) * (W/nf + 0.18u)' nrd='0.18u / W' nrs='0.18u / W' sa=0 sb=0 sd=0 m=1
.ends ota_nmos

.global GND
.end
