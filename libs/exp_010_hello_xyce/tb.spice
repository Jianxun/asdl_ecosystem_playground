* Netlist generated by ASDL for backend `sim.xyce`

Xdut vin vout vss vdd inv
V_vsrc_vdd vdd vss DC 3.3
V_vsrc_vss vss 0 DC 0
V_vsrc_in vin vss DC 0
* GF180MCU Model Card:
.include /Users/jianxunzhu/Documents/GitHub/asdl_ecosystem/playground/pdks/gf180mcu/xyce/design.xyce
.lib /Users/jianxunzhu/Documents/GitHub/asdl_ecosystem/playground/pdks/gf180mcu/xyce/sm141064.xyce typical
.DC V_vsrc_in 0 3.3 0.01

.PRINT DC FORMAT=raw V(*)

* ===============================================
* inv
* /Users/jianxunzhu/Documents/GitHub/asdl_ecosystem/playground/libs/exp_010_hello_xyce/inv.asdl
* ===============================================
.subckt inv in out vss vdd
Xmn out in vss vss nfet_03v3 L=0.5u W=6*5u nf=6 ad='int((nf+1)/2) * W/nf * 0.18u' as='int((nf+2)/2) * W/nf * 0.18u' pd='2*int((nf+1)/2) * (W/nf + 0.18u)'
+ ps='2*int((nf+2)/2) * (W/nf + 0.18u)' nrd='0.18u / W' nrs='0.18u / W' sa=0 sb=0 sd=0 m=16
Xmp out in vdd vdd pfet_03v3 L=0.5u W=6*5u nf=6 ad='int((nf+1)/2) * W/nf * 0.18u' as='int((nf+2)/2) * W/nf * 0.18u' pd='2*int((nf+1)/2) * (W/nf + 0.18u)'
+ ps='2*int((nf+2)/2) * (W/nf + 0.18u)' nrd='0.18u / W' nrs='0.18u / W' sa=0 sb=0 sd=0 m=48
.ends inv

.global GND
.end
