* Netlist generated by ASDL for backend `sim.xyce`

V_vin vin 0 DC 0 AC 0 0 PULSE (0 1 100e-9 1e-9 1e-9 20e-6 40e-6)
R_r1 vin vout 1k
C_c1 vout 0 1n
.TRAN 1e-08 2e-05 0

.PRINT TRAN FORMAT=csv V(vin) V(vout)

.global GND
.end
