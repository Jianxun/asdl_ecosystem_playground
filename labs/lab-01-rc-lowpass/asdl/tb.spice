* Netlist generated by ASDL for backend `sim.xyce`

V_vin vin 0 DC 0 AC 1 0 PULSE (0 0 100e-9 1e-9 1e-9 20e-6 40e-6)
R_r1 vin vout 1k
C_c1 vout 0 1n
.AC DEC 100 100.0 100000000.0

.PRINT AC FORMAT=csv V(vin) V(vout)

.global GND
.end
