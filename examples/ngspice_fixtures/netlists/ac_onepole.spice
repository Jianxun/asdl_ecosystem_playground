* ac_onepole.spice -- one-pole RC low-pass AC fixture
Vin in 0 AC 1
R1 in out 1k
C1 out 0 1n

.save v(in) v(out)
.ac dec 200 10 1e6
.end
