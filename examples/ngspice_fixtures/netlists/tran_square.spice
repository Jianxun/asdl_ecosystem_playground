* tran_square.spice -- deterministic square-wave transient fixture
V1 in 0 PULSE(0 1.2 0 1n 1n 5u 10u)
R1 in out 1k
C1 out 0 1n

.save v(in) v(out)
.tran 100n 100u
.end
